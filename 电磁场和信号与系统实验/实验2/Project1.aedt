# Ansys Electronics Desktop project, version 2024.2
materials:
  vacuum: permittivity=1
  copper: permeability=0.999991 conductivity=58000000
  air: permittivity=1.0006 permeability=1.0000004

design Maxwell2DDesign1 (Maxwell 2D, EddyCurrent, about Z geometry, model units cm)
geometry:
  Rectangle1 [copper] = rectangle(corner=(2.7cm, 0cm, -11.5cm), z_size=23cm, x_size=0.4cm)
  Region [air] = region(percentage_offset: +X=100, -X=100, +Y=0, -Y=0, +Z=100, -Z=100)
  Polyline1 [non-model] = polyline((0cm, 0cm, -24cm) (0cm, 0cm, 24cm))
boundaries and excitations:
  Symmetry1: Symmetry Edges=Region.edge(at (0, 0, 0)) IsOdd=true
  Balloon1: Balloon Edges=Region.edge(at (3.5, 0, 0), at (1.75, 0, 34.5), at (1.75, 0, -34.5))
  Rectangle1: Coil Objects=Rectangle1 Conductor_number=1860 Winding=Winding1 PolarityType=Positive
  Winding1: Winding Group Type=Current IsSolid=false Current=0.5A ParallelBranchesNum=1 Phase=0deg
  eddy effects on: Rectangle1
parameters:
  Matrix1: Matrix Winding1:
mesh:
  initial mesh: GlobalSurfApproximation{CurvedSurfaceApproxChoice=UseSlider SliderMeshSettings=7}
setups:
  Setup1: EddyCurrent MaximumPasses=50 MinimumPasses=2 MinimumConvergedPasses=1 PercentRefinement=30 PercentError=1 NonLinearResidual=0.0001 Frequency=50Hz
reports:
  Calculator Expressions Plot 1: Mag_H vs Distance on Setup1 : LastAdaptive [Freq=all Phase=0deg]
